* This deck is intentionally invalid and is used in the documentation
.include "broken/cycle_a.sp"
.param repeated=1 repeated=2
Xmissing in out absent_cell
.end
