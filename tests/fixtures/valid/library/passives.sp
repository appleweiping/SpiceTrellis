.subckt divider input output RUP=10k RDOWN=10k
Rup input output {RUP}
Rdown output 0 {RDOWN}
.ends divider
